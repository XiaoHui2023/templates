block blk_pll_sc {
  bytes 4;

  register pd @'h100 {
    bytes 4;
    field vocpd @0 { bits 1; access rw; }
    field postdivpd @1 { bits 1; access rw; }
    field dsmpd @2 { bits 1; access rw; }
    field pd @3 { bits 1; access rw; }
    field bypass @4 { bits 1; access rw; }
  }

  register div @'h104 {
    bytes 4;
    field refdiv @0 { bits 6; access rw; }
    field postdiv2 @8 { bits 3; access rw; }
    field postdiv1 @12 { bits 3; access rw; }
    field fbdiv @16 { bits 12; access rw; }
  }

  register stat @'h108 {
    bytes 4;
    field lock @0 { bits 1; access ro; }
  }
}

block blk_div0 {
  bytes 4;

  register ctrl @'h200 {
    bytes 4;
    field rst @0 { bits 1; access rw; }
    field load @1 { bits 1; access rw; }
    field div @8 { bits 8; access rw; }
  }
}

block blk_cpu_gate0 {
  bytes 4;

  register ctrl @'h240 {
    bytes 4;
    field rst @0 { bits 1; access rw; }
    field div @8 { bits 4; access rw; }
  }
}

block blk_mux_ref {
  bytes 4;

  register sel @'h300 {
    bytes 4;
    field sel @0 { bits 2; access rw; }
  }
}

block blk_gate0 {
  bytes 4;

  register en @'h400 {
    bytes 4;
    field en @0 { bits 1; access rw; }
  }
}
